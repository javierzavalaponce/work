* Barrido DC de V1
V1 in 0 DC 0
R1 in out 1k
R2 out 0 1k

.dc V1 0 15 1.0
.print v(out) i(V1)
.end
