V1 in 0 PULSE(0 1 0 1m 1m 10 20)
R1 in out 1k
C1 out 0 100u

.tran 1

.end
